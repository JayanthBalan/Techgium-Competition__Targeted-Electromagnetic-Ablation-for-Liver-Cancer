# Ansys Electronics Desktop project, version 2024.2
materials:
  vacuum: permittivity=1
  copper: permeability=0.999991 conductivity=58000000 mass_density=8933
  Rogers RT/duroid 5880 (tm): permittivity=2.2 dielectric_loss_tangent=0.0009
  glass: permittivity=5.5 mass_density=2500
  Dupont Type 100 HN Film (tm): permittivity=3.5 dielectric_loss_tangent=0.0026
  Cancer_cell: permittivity=55 conductivity=0.2 dielectric_loss_tangent=0.35 mass_density=1075 delta_H_freq=2450000000
  Glisson's_capsule: permittivity=45 conductivity=0.03 dielectric_loss_tangent=0.15 mass_density=1150
  liver_tissue: permittivity=178 conductivity=0.337
  glass_PTFEreinf: permittivity=2.5 dielectric_loss_tangent=0.002
  Alumina PDMS: permittivity=4.3 dielectric_loss_tangent=0.01

design HFSSDesigncancer1 (HFSS, HFSS Terminal Network, model units mm)
variables:
  Helix_r = 1.65mm
  Helix_a = 0.319mm
  Helix_n = 8
  Helix_s = 5mm
  Ground_r = Helix_r+Sub_t+Helix_a+0.0125mm
  Ground_t = 1mm
  Helix_off = Helix_r
  Feed_l1 = 1mm
  Feed_l2 = 1mm
  Feed_l = Feed_l1+Feed_l2+Ground_t
  Feed_r = Helix_a
  Sub_t = 1.5*Helix_a
geometry:
  Ground [copper] = cylinder(axis=Z, base_centre=(0mm, 0mm, -Ground_t), radius=Ground_r, height=Ground_t+1mm)
  coordinate_system Helix_Base = origin=(0mm, Feed_r, Feed_l1) x=(1mm, 0mm, 0mm) y=(0mm, 1mm, 0mm)
  Helix [copper] = circle(normal=Y, centre=(Helix_off, 0mm, Helix_a), radius=Helix_a) in Helix_Base
  Helix.helix(XCenter=0mm YCenter=0mm ZCenter=0mm XStartDir=0mm YStartDir=0mm ZStartDir=1.4mm NumThread=Helix_n RightHand=true RadiusIncrement=0mm Thread=Helix_s) in Helix_Base
  coordinate_system Antenna_Base = origin=(0mm, 0mm, -(Ground_t+Feed_l2)) x=(1mm, 0mm, 0mm) y=(0mm, 1mm, 0mm)
  Feedline = cylinder(axis=Z, base_centre=(Helix_off, 0mm, 0mm), radius=Feed_r, height=Feed_l) in Antenna_Base
  Substrate [Rogers RT/duroid 5880 (tm)] = cylinder(axis=Z, base_centre=(Helix_off, 0mm, 0mm), radius=Feed_r+Sub_t, height=Feed_l) in Antenna_Base
  Feedline_1 = Feedline.copy()
  Ground.subtract(Feedline_1)
  Groundline [copper] = cylinder(axis=Z, base_centre=(Helix_off, 0mm, 0mm), radius=2*Feed_r+Sub_t, height=Feed_l2) in Antenna_Base
  Feedline_2 = Feedline.copy()
  Substrate.subtract(Feedline_2)
  Substrate_1 = Substrate.copy()
  Ground.subtract(Substrate_1)
  Feedline_3 = Feedline.copy()
  Substrate_2 = Substrate.copy()
  Groundline.subtract(Feedline_3, Substrate_2)
  Port = circle(normal=Z, centre=(Helix_off, 0mm, 0mm), radius=2*Feed_r+Sub_t) in Antenna_Base
  Connector = circle(normal=Z, centre=(Helix_off, -Feed_r, 0mm), radius=Helix_a) in Helix_Base
  Polyline1 = polyline(x=1.65mm, yz in mm: (-0.638, 0) (-0.5, 0.35) (0, 0.638), Arc from point 0 over 3) in Helix_Base
  Connector.sweep_along_path(Polyline1)
  Helix.unite(Connector)
  Cylinder1 = cylinder(axis=Z, base_centre=(0mm, 0mm, 0mm), radius=Helix_r+Helix_a+0.07mm, height=Helix_s*(Helix_n+0.15)) in Helix_Base
  Casing [glass_PTFEreinf] = cylinder(axis=Z, base_centre=(0mm, 0mm, Feed_l1), radius=Helix_r+Sub_t+Helix_a+0.0125mm, height=Helix_s*Helix_n+2*Feed_l1/3+0.25mm)
  Helix.unite(Feedline)
  Helix_1 = Helix.copy()
  Substrate_4 = Substrate.copy()
  Ground.subtract(Helix_1, Substrate_4)
  Cylinder1_1 = Cylinder1.copy()
  Cylinder1.delete()
  Casing.subtract(Cylinder1_1)
  Casing_front [Dupont Type 100 HN Film (tm)] = cylinder(axis=Z, base_centre=(0mm, 0mm, Ground_t+0.1mm), radius=Ground_r+0.4mm, height=-Feed_l1*4-Ground_t-0.1mm)
  coordinate_system Helix_Base1 = origin=(0mm, Feed_r, Feed_l1) x=(1mm, 0mm, 0mm) y=(0mm, 1mm, 0mm)
  Head = cone(axis=Z, base_centre=(0mm, 0mm, -Feed_l1*3-Feed_l2), bottom_radius=Ground_r+0.4mm, top_radius=0, height=-Feed_l)
  Groundline_1 = Groundline.copy()
  Helix_2 = Helix.copy()
  Substrate_5 = Substrate.copy()
  Casing_front.subtract(Groundline_1, Helix_2, Substrate_5)
  Casing_front.unite(Head)
  coordinate_system phantom = origin=(0.15mm, 0.15mm, 50mm) x=(1mm, 0mm, 0mm) y=(0mm, 1mm, 0mm)
  Cancer_cell [Cancer_cell] = sphere(centre=(0.15mm, 0.15mm, -80mm), radius=20mm) in phantom
  Casing_3 = Casing.copy()
  Ground_3 = Ground.copy()
  Casing_front.subtract(Casing_3, Ground_3)
  RadiatingSurface [vacuum] = region(absolute_offset=7.751938mm on all sides) in phantom
  Lens [Alumina PDMS] = sphere(centre=(0mm, 0mm, Ground_t+2.5mm), radius=7mm)
  Sphere2 = sphere(centre=(0mm, 0mm, Ground_t-10.4mm), radius=7mm)
  Lens.intersect(Sphere2)
  Lens_1 = Lens.copy()
  Casing_front.subtract(Lens_1)
boundaries and excitations:
  Open1: Radiation Objects=RadiatingSurface
  1: Lumped Port Objects=Port LumpedPortType=Modal Modes{Mode1{IntLine{(1650mm, 744.33333mm, -2000mm) -> (1.65, 0.319, -2)} CharImp=Zpi RenormImp=50ohm}} Impedance=50ohm
setups:
  13p7: HfssDriven Frequency=13.7GHz MaxDeltaS=0.02 MaximumPasses=12 MinimumPasses=1 MinimumConvergedPasses=1 PercentRefinement=30 BasisOrder=1 PortAccuracy=2 DrivenSolverType="Direct Solver"
  13p9: HfssDriven Frequency=13.9GHz MaxDeltaS=0.02 MaximumPasses=12 MinimumPasses=1 MinimumConvergedPasses=1 PercentRefinement=30 BasisOrder=1 PortAccuracy=2 DrivenSolverType="Direct Solver"
  Setup1: HfssDriven MultipleAdaptiveFreqsSetup{AdaptAt{Frequency=12.9GHz Delta=0.02} AdaptAt{Frequency=13.7GHz Delta=0.02} AdaptAt{Frequency=13.9GHz Delta=0.02}} MaximumPasses=12 MinimumPasses=1 MinimumConvergedPasses=1 PercentRefinement=30 BasisOrder=1 PortAccuracy=2 DrivenSolverType="Direct Solver"
    sweep Sweep: 11.15GHz to 14.55GHz, 101 points; Type=Fast SaveFields
source amplitudes:
  1:1: 1V 0deg
radiation setups:
  3D: Infinite Sphere Theta=-180deg..180deg step 2deg Phi=-180deg..180deg step 2deg CoordSystem=phantom
  Elevation: Infinite Sphere Theta=-180deg..180deg step 1deg Phi=0deg..90deg step 90deg CoordSystem=phantom
  Azimuth: Infinite Sphere Theta=90deg..90deg step 0deg Phi=-180deg..180deg step 1deg CoordSystem=phantom
field plots:
  Local_SAR1: SAR Field in Cancer_cell on Setup1 : LastAdaptive at Freq=12.9GHz Phase=0deg
reports:
  S Parameter Plot 1: dB(S(1,1)) vs Freq on Setup1 : Sweep
  Gain Plot 1: GainTotal vs Phi, Theta on 13p7 : LastAdaptive, 3D [Freq=13.7GHz]
  Gain Plot 2: GainTotal vs Phi, Theta on 13p9 : LastAdaptive, 3D [Freq=13.9GHz]
  Gain Plot 3: dB(GainTotal) vs Theta on Setup1 : LastAdaptive, 3D [Phi=0deg Freq=12.9GHz,13.7GHz,13.9GHz]

design HFSSDesignLiver (HFSS, HFSS Terminal Network, model units mm)
variables:
  Helix_r = 1.65mm
  Helix_a = 0.319mm
  Helix_n = 8
  Helix_s = 5mm
  Ground_r = Helix_r+Sub_t+Helix_a+0.0125mm
  Ground_t = 1mm
  Helix_off = Helix_r
  Feed_l1 = 1mm
  Feed_l2 = 1mm
  Feed_l = Feed_l1+Feed_l2+Ground_t
  Feed_r = Helix_a
  Sub_t = 1.5*Helix_a
geometry:
  Ground [copper] = cylinder(axis=Z, base_centre=(0mm, 0mm, -Ground_t), radius=Ground_r, height=Ground_t+1mm)
  coordinate_system Helix_Base = origin=(0mm, Feed_r, Feed_l1) x=(1mm, 0mm, 0mm) y=(0mm, 1mm, 0mm)
  Helix [copper] = circle(normal=Y, centre=(Helix_off, 0mm, Helix_a), radius=Helix_a) in Helix_Base
  Helix.helix(XCenter=0mm YCenter=0mm ZCenter=0mm XStartDir=0mm YStartDir=0mm ZStartDir=1.4mm NumThread=Helix_n RightHand=true RadiusIncrement=0mm Thread=Helix_s) in Helix_Base
  coordinate_system Antenna_Base = origin=(0mm, 0mm, -(Ground_t+Feed_l2)) x=(1mm, 0mm, 0mm) y=(0mm, 1mm, 0mm)
  Feedline = cylinder(axis=Z, base_centre=(Helix_off, 0mm, 0mm), radius=Feed_r, height=Feed_l) in Antenna_Base
  Substrate [Rogers RT/duroid 5880 (tm)] = cylinder(axis=Z, base_centre=(Helix_off, 0mm, 0mm), radius=Feed_r+Sub_t, height=Feed_l) in Antenna_Base
  Feedline_1 = Feedline.copy()
  Ground.subtract(Feedline_1)
  Groundline [copper] = cylinder(axis=Z, base_centre=(Helix_off, 0mm, 0mm), radius=2*Feed_r+Sub_t, height=Feed_l2) in Antenna_Base
  Feedline_2 = Feedline.copy()
  Substrate.subtract(Feedline_2)
  Substrate_1 = Substrate.copy()
  Ground.subtract(Substrate_1)
  Feedline_3 = Feedline.copy()
  Substrate_2 = Substrate.copy()
  Groundline.subtract(Feedline_3, Substrate_2)
  Port = circle(normal=Z, centre=(Helix_off, 0mm, 0mm), radius=2*Feed_r+Sub_t) in Antenna_Base
  Connector = circle(normal=Z, centre=(Helix_off, -Feed_r, 0mm), radius=Helix_a) in Helix_Base
  Polyline1 = polyline(x=1.65mm, yz in mm: (-0.638, 0) (-0.5, 0.35) (0, 0.638), Arc from point 0 over 3) in Helix_Base
  Connector.sweep_along_path(Polyline1)
  Helix.unite(Connector)
  Cylinder1 = cylinder(axis=Z, base_centre=(0mm, 0mm, 0mm), radius=Helix_r+Helix_a+0.07mm, height=Helix_s*(Helix_n+0.15)) in Helix_Base
  Casing [glass_PTFEreinf] = cylinder(axis=Z, base_centre=(0mm, 0mm, Feed_l1), radius=Helix_r+Sub_t+Helix_a+0.0125mm, height=Helix_s*Helix_n+2*Feed_l1/3+0.25mm)
  Helix.unite(Feedline)
  Helix_1 = Helix.copy()
  Substrate_4 = Substrate.copy()
  Ground.subtract(Helix_1, Substrate_4)
  Cylinder1_1 = Cylinder1.copy()
  Cylinder1.delete()
  Casing.subtract(Cylinder1_1)
  Casing_front [Dupont Type 100 HN Film (tm)] = cylinder(axis=Z, base_centre=(0mm, 0mm, Ground_t+0.1mm), radius=Ground_r+0.4mm, height=-Feed_l1*4-Ground_t-0.1mm)
  coordinate_system Helix_Base1 = origin=(0mm, Feed_r, Feed_l1) x=(1mm, 0mm, 0mm) y=(0mm, 1mm, 0mm)
  Head = cone(axis=Z, base_centre=(0mm, 0mm, -Feed_l1*3-Feed_l2), bottom_radius=Ground_r+0.4mm, top_radius=0, height=-Feed_l)
  Groundline_1 = Groundline.copy()
  Helix_2 = Helix.copy()
  Substrate_5 = Substrate.copy()
  Casing_front.subtract(Groundline_1, Helix_2, Substrate_5)
  Casing_front.unite(Head)
  coordinate_system phantom = origin=(0.15mm, 0.15mm, 50mm) x=(1mm, 0mm, 0mm) y=(0mm, 1mm, 0mm)
  Liver [liver_tissue] = sphere(centre=(0.15mm, 0.15mm, -80mm), radius=20mm) in phantom
  Casing_3 = Casing.copy()
  Ground_3 = Ground.copy()
  Casing_front.subtract(Casing_3, Ground_3)
  RadiatingSurface [vacuum] = region(absolute_offset=7.751938mm on all sides) in phantom
  Lens [Alumina PDMS] = sphere(centre=(0mm, 0mm, Ground_t+2.5mm), radius=7mm)
  Sphere2 = sphere(centre=(0mm, 0mm, Ground_t-10.4mm), radius=7mm)
  Lens.intersect(Sphere2)
  Lens_1 = Lens.copy()
  Casing_front.subtract(Lens_1)
boundaries and excitations:
  Open1: Radiation Objects=RadiatingSurface
  1: Lumped Port Objects=Port LumpedPortType=Modal Modes{Mode1{IntLine{(1650mm, 744.33333mm, -2000mm) -> (1.65, 0.319, -2)} CharImp=Zpi RenormImp=50ohm}} Impedance=50ohm
setups:
  13p7: HfssDriven Frequency=13.7GHz MaxDeltaS=0.02 MaximumPasses=12 MinimumPasses=1 MinimumConvergedPasses=1 PercentRefinement=30 BasisOrder=1 PortAccuracy=2 DrivenSolverType="Direct Solver"
  13p9: HfssDriven Frequency=13.9GHz MaxDeltaS=0.02 MaximumPasses=12 MinimumPasses=1 MinimumConvergedPasses=1 PercentRefinement=30 BasisOrder=1 PortAccuracy=2 DrivenSolverType="Direct Solver"
  Setup1: HfssDriven MultipleAdaptiveFreqsSetup{AdaptAt{Frequency=12.7GHz Delta=0.02} AdaptAt{Frequency=13.7GHz Delta=0.02} AdaptAt{Frequency=13.9GHz Delta=0.02}} MaximumPasses=12 MinimumPasses=1 MinimumConvergedPasses=1 PercentRefinement=30 BasisOrder=1 PortAccuracy=2 DrivenSolverType="Direct Solver"
    sweep Sweep: 11.15GHz to 14.55GHz, 101 points; Type=Fast SaveFields
source amplitudes:
  1:1: 1V 0deg
radiation setups:
  3D: Infinite Sphere Theta=-180deg..180deg step 2deg Phi=-180deg..180deg step 2deg CoordSystem=phantom
  Elevation: Infinite Sphere Theta=-180deg..180deg step 1deg Phi=0deg..90deg step 90deg CoordSystem=phantom
  Azimuth: Infinite Sphere Theta=90deg..90deg step 0deg Phi=-180deg..180deg step 1deg CoordSystem=phantom
field plots:
  Local_SAR1: SAR Field in Liver on Setup1 : LastAdaptive at Freq=13.7GHz Phase=0deg
  Local_SAR2: SAR Field over Liver.face(at (-19.7, 0.3, -30)) on 13p7 : LastAdaptive at Freq=13.7GHz Phase=0deg
reports:
  S Parameter Plot 1: dB(S(1,1)) vs Freq on Setup1 : Sweep
  Gain Plot 1: GainTotal vs Phi, Theta on 13p7 : LastAdaptive, 3D [Freq=13.7GHz]
  Gain Plot 2: GainTotal vs Phi, Theta on 13p9 : LastAdaptive, 3D [Freq=13.9GHz]
  Gain Plot 3: dB(GainTotal) vs Theta on Setup1 : LastAdaptive, 3D [Phi=0deg Freq=12.7GHz,13.7GHz,13.9GHz]
